signal {signalwidth=1; sync; activehigh;} my_signal;

addrmap addrmap_with_signal {
    default regwidth = 32;
    default accesswidth = 32;

    signal {signalwidth=1; sync; activehigh;
    } my_signal;

    reg {
        default sw = r;
        default hw = w;

        field {} my_field[32];
    } my_reg;

    my_reg.my_field->resetsignal = my_signal;
};