
addrmap multifile {
    reg {
        default sw = rw;
        default hw = r;
        field { sw=r; } header[31:0] = 0x1;
    } header_reg;

    simple__simple_mmap__simple simple_regs;
};
