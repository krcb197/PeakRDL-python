
property python_inst_name { type = string; component = addrmap | regfile | reg | field | mem; };

addrmap name_clash {

	enum direction {
		in = 0 { name = "In"; };
		out = 1 { name = "Out"; };
	};

    reg {
        default sw = rw;
        default hw = r;
        <%for( $i = 0; $i < 8; $i += 1 ) {%>
        field { encode = direction; fieldwidth=1; } gpio_<%=$i%>_direction = {direction::in};
        <% } %>
    } gpio_direction;

    reg {
        field { fieldwidth=1; } pass = 1;
        field { fieldwidth=2; } _pain = 3;
        field { fieldwidth=1; } finally = 1;
        field { fieldwidth=1; } yield = 1;
        field { fieldwidth=1; } in = 1;
        field { fieldwidth=1; } field_in = 1;
    } gpio_status;

    reg {
        field { fieldwidth=1; } msb = 1;
        field { fieldwidth=1; python_inst_name="pass_field"; } pass = 1;
    } msb;

    addrmap {
        addrmap {
            regfile {
                reg {
                    field { fieldwidth=16; } address;
                } address;
            } address;
        } address;
    } single_entry;

    addrmap {
        addrmap {
            regfile {
                reg {
                    field { fieldwidth=16; } address;
                } address[2];
            } address[2];
        } address[2];
    } array_entry;

    external mem {
        mementries = 4;
        memwidth = 32;
    } yield;
};