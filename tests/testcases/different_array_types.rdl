addrmap different_array_types {

    reg {
        default sw = rw;
        default hw = r;
        field {} basicfield_a[31:0];
    } read_write_array[4];

    reg {
        default sw = rw;
        default hw = r;
        field {} basicfield_a[31:0];
    } read_write_array_2D[6][7];

    reg {
        default sw = rw;
        default hw = r;
        field {} basicfield_a[31:0];
    } read_write_array_3D[6][7][8];

    regfile {
        reg {
            default sw = rw;
            default hw = r;
            field {} basicfield_a[31:0];
        } read_write_array_inner[8];
        regfile {
            reg {
                default sw = rw;
                default hw = r;
                field {} basicfield_a[31:0];
            } read_write_array_deep_inner[6];
        } regfile_array_inner[3];
    } regfile_array[2];


};