property python_hide { type = boolean; component = addrmap | regfile | reg | field | mem; };

addrmap hidden_fields {

    reg {
        default sw = rw;
        default hw = r;
        python_hide = true;
        field { python_hide=true; fieldwidth=1; } property_hidden_field;
        field { python_hide=false; fieldwidth=1; } property_unhidden_field;
        field { fieldwidth=1; } no_property_field;
    } reg_with_fields;
};