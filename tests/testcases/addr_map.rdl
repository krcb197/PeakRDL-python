
reg regtype_a {
        default sw = rw;
        default hw = r;
        field {} basicfield_a[31:0];
    };

addrmap child_addr_map_type_a {
    regtype_a  basicreg_a;
};

addrmap child_addr_map_type_b {
    regtype_a basicreg_a;

    regfile {
        regtype_a basicreg_a;
    } regfile_a[2];
};

addrmap child_addr_map_type_c {

    child_addr_map_type_b child_b[2];

    reg {
        default sw = rw;
        default hw = r;
        field {} basicfield_a[15:0];
    } basicreg_c;
};

addrmap addr_map {
    regtype_a top_reg;
    child_addr_map_type_a child_a;
    child_addr_map_type_b child_b[2];
    child_addr_map_type_c child_c;
    child_addr_map_type_b child_b_offset[2] += 48;

};
