addrmap regfile_and_arrays {

    reg basic_reg_Type {
        default sw = rw;
        default hw = r;
        field {} basicfield_a[31:0];
    };

    regfile {
        basic_reg_Type basic_reg_a;
    } layer1_regfile_a[2];

    regfile {
        regfile {
			desc = "some description of the";
            reg basic_reg_Type2 {
                default sw = r;
                default hw = r;
                field {} basicfield_a[31:0];
            };
            basic_reg_Type basic_reg_a[3];
            basic_reg_Type2 basic_reg_b;
        } layer2_regfile_a[4];
    } layer1_regfile_b;

};