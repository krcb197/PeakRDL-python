addrmap basic {

    reg {
        default sw = rw;
        default hw = r;
        field {} basicfield_a[31:0];
    } basicreg_a;

    reg {
        default sw = rw;
        default hw = r;
        field { sw = r; } basicfield_b[31:16];
        field {} basicfield_c[15:0];
    } basicreg_b;

    reg {
        default sw = r;
        default hw = r;
        field {  } basicfield_d[31:16];

    } basicreg_c;

};